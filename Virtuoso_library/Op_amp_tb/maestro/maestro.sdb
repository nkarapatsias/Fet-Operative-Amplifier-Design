ADE simulation setup
Run mode: Monte Carlo Sampling
Tests:
  Op_amp_Op_amp_tb_1: Op_amp/Op_amp_tb/schematic, simulator spectre
    Outputs: A0; Isupp; Voffset; Slew rate
Corners:
  model folders: /mnt/apps/prebuilt/EDA/designkits/GPDK/gpdk045_v_6_0/gpdk045/../models/spectre
  FF (off): temperature=-40 125; gpdk045.scs[ff]
  SS (off): temperature=-40 125
  MC (off): gpdk045.scs[mc]
  FF_T_125: temperature=125; gpdk045.scs[ff]
  SS_T_M40: temperature=-40; gpdk045.scs[ss]
Monte Carlo Sampling options: mcnumpoints=200, pointsPerJobPolicy=Group automatically, yeyistostart=3.0, reliabilitymode=singlestress, maxPointsPerJob=10, mcSigmaTarget=3, sssnumpoints=7000, yeexpectedyield=3, mcmethod=mismatch, wcdinitialpoints=200, yeiterations=10, yeusehistorymc=0, yeuseautomcsamples=1, yecreatecorners=0, parasiticanalysis=0, mcFilterPluginEnabled=0, haveyeyieldtostart=1, yeusevarreduction=1
