ADE simulation setup
Test Op_amp_Op_amp_tb_1: Op_amp/Op_amp_tb/schematic, simulator spectre
  Models: /mnt/apps/prebuilt/EDA/designkits/GPDK/gpdk045_v_6_0/gpdk045/../models/spectre/gpdk045.scs[mc]
  Temperature: 27
  Analysis dc: (saves the operating point)
  Output GBW = getData("phaseMarginFreq" ?result "stb_margin") (unticked)
  Output PM = getData("phaseMargin" ?result "stb_margin") (unticked)
  Output A0 = value(db(mag(getData("loopGain" ?result "stb"))) 1) (unticked)
  Output Isupp = IDC("/V0/MINUS") (unticked)
  Output Voffset = (VDC("/V4/PLUS") - VDC("/I0/Out"))
  Output Slew rate = ymax(deriv(vtime('tran "/net4"))) (unticked)
  Signals: /V0/MINUS (terminal), /V4/PLUS (terminal) as /V4/PLUS_V, /I0/Out
